* Forge ngspice smoke: RC step response, tau = R*C = 1 ms; v(out) at t = tau should be 1 - e^-1 = 0.63212 V
V1 in 0 PWL(0 0 1n 1)
R1 in out 1k
C1 out 0 1u
.tran 1u 5m
.meas tran vtau FIND v(out) AT=1m
.end
